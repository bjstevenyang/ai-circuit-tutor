Complementary oscillator variant, 240k bias, unchanged complete cards, 27 C
Vbat VP 0 PWL(0 0 100u 9)
R3 VP P 47
R1 P A 240k
Q1 B A 0 Q2N3904
Q2 D B P Q2N3906
C1 A D 100n IC=0
Rspk D S 8
R2 S 0 10
.model Q2N3904 NPN(IS=6.734f XTI=3 EG=1.11 VAF=74.03 BF=416.4 NE=1.259 ISE=6.734f
+ IKF=66.78m XTB=1.5 BR=.7371 NC=2 ISC=0 IKR=0 RC=1
+ CJC=3.638p MJC=.3085 VJC=.75 FC=.5 CJE=4.493p MJE=.2593 VJE=.75
+ TR=239.5n TF=301.2p ITF=.4 VTF=4 XTF=2 RB=10)
.model Q2N3906 PNP(IS=1.41f XTI=3 EG=1.11 VAF=18.7 BF=180.7 NE=1.5 ISE=0
+ IKF=80m XTB=1.5 BR=4.977 NC=2 ISC=0 IKR=0 RC=2.5
+ CJC=9.728p MJC=.5776 VJC=.75 FC=.5 CJE=8.063p MJE=.3677 VJE=.75
+ TR=33.42n TF=179.3p ITF=.4 VTF=4 XTF=6 RB=10)
.temp 27
.options reltol=1e-4 vntol=10u abstol=1n
.save v(A) v(B) v(P) v(D) v(S) i(Vbat)
.tran .25u 40m 0 .25u uic
.end
